* Pass-device sizing: drain current per um of width at |Vsd| = 0.3 V vs |Vsg| (TT, 27C)
* Usage: ngspice -b pass_sizing.spice   -> results/pass_sizing.txt (cols: vg I1 vg I2 vg I3, A per 10um)
.lib /usr/local/share/pdk/sky130A/libs.tech/combined/sky130.lib.spice tt
Vin vin 0 1.8
Vo1 o1 0 1.5
Vo2 o2 0 1.5
Vo3 o3 0 1.5
Vg g 0 0
XP1 o1 g vin vin sky130_fd_pr__pfet_01v8 L=0.15 W=10 nf=1
XP2 o2 g vin vin sky130_fd_pr__pfet_01v8 L=0.35 W=10 nf=1
XP3 o3 g vin vin sky130_fd_pr__pfet_01v8_lvt L=0.35 W=10 nf=1
.control
dc Vg 0 1.8 0.05
wrdata ../../results/pass_sizing.txt i(Vo1) i(Vo2) i(Vo3)
.endc
.end
