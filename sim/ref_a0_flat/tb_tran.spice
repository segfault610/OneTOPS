* Load transient: ILOAD 0.1 mA <-> 10 mA, edge time TR (default 100 ns), CL = 100 pF on-chip
.include tb_common.spice
.include ldo_fvf_base.spice
.param TR=100n
Vin vin 0 {VIN}
Vref vref 0 {VREF}
Ib vin ibn {IB}
Xldo vin vout vref 0 ibn ldo_fvf_base
Il vout 0 pwl(0 0.1m 2u 0.1m {2u+TR} 10m 6u 10m {6u+TR} 0.1m 12u 0.1m)
Cl vout 0 {CL}
.control
tran 1n 12u
meas tran vpre find v(vout) at=1.9u
meas tran vmin min v(vout) from=2u to=6u
meas tran vmax max v(vout) from=6u to=12u
meas tran vhi find v(vout) at=5.9u
meas tran vend find v(vout) at=11.9u
let under_mV = (vpre - vmin)*1000
let over_mV = (vmax - vhi)*1000
print under_mV over_mV
* 1% settling (12 mV) after the rising edge
let thr = vhi - 0.012
meas tran tset when v(vout)=thr cross=last from=2u to=6u
let tsettle_ns = (tset - 2u)*1e9
print tsettle_ns
wrdata ../../results/ldo_base_tran.txt v(vout) v(xldo.x)
.endc
.end
